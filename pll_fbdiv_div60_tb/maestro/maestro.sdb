ADE simulation setup
Run mode: Single Run, Sweeps and Corners
Tests:
  cg_PLL_pll_fbdiv_div60_tb_1: cg_PLL/pll_fbdiv_div60_tb/schematic, simulator eldoD
    Variables: fin = 500e6
