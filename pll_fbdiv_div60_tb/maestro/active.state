ADE simulation setup
Test cg_PLL_pll_fbdiv_div60_tb_1: cg_PLL/pll_fbdiv_div60_tb/schematic, simulator eldoD
  Models: /eda/foundry/TSMC/TSMC65_VCAD_V1.7A_Base/Base_PDK/V1.7A_1/1p9m6x1z1u/tsmcN65/../models/eldo/toplevel.eldo[tt_lib]
  Variables: fin = 500e6
  Analysis tran
  Analysis dc
Run mode: Single Run, Sweeps and Corners
