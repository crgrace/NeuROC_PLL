ADE simulation setup
Run mode: Single Run, Sweeps and Corners
Tests:
  cg_PLL_pll_pfd_tb_1: cg_PLL/pll_pfd_tb/schematic, simulator eldoD
    Variables: vdda = 1.2; f_in = 60e6; delta_f = 500k
