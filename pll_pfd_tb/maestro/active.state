ADE simulation setup
Test cg_PLL_pll_pfd_tb_1: cg_PLL/pll_pfd_tb/schematic, simulator eldoD
  Models: /eda/foundry/TSMC/TSMC65_VCAD_V1.7A_Base/Base_PDK/V1.7A_1/1p9m6x1z1u/tsmcN65/../models/eldo/toplevel.eldo[mismatch_lib], /home/lxusers/c/crgrace/projects/65nm/cadence/cadence/eldo_models/lowT_models_eldo/lvmos_mac.lib[tt]
  Variables: vdda = 1.2; f_in = 60e6; delta_f = 500k
  Analysis tran
  Analysis dc
Run mode: Single Run, Sweeps and Corners
