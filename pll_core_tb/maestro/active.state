ADE simulation setup
Test cg_PLL_pll_core_tb_1: cg_PLL/pll_core_tb/schematic, simulator eldoD
  Models: /eda/foundry/TSMC/TSMC65_VCAD_V1.7A_Base/Base_PDK/V1.7A_1/1p9m6x1z1u/tsmcN65/../models/eldo/toplevel.eldo[mismatch_lib], /home/lxusers/c/crgrace/projects/65nm/cadence/cadence/eldo_models/lowT_models_eldo/lvmos_mac.lib[tt]
  Variables: iota = 5u; f_in = 40e6; vdda = 1.2; reset = 0; r1 = 5k; icp = 10u; c2 = 4p; c1 = 40p
  Initial conditions: /DUT/VCO/vo<0> = 0
  Analysis dc
  Analysis tran
  Signals: /clk_out, /DUT/vctrl, /DUT/vco_out, /DUT/fbdiv_out, /DUT/reset_in_buff, /pll_locked, /DUT/LOCK_DETECT/up_buff, /DUT/LOCK_DETECT/dn_buff, /DUT/up, /DUT/dn, /DUT/LOCK_DETECT/net1, /DUT/LOCK_DETECT/analog_detect, /reset_n, /DUT/LOCK_DETECT/net3, /fbclk_out, /refclk_in, /icp_sink, /ibias_sink_5u, /DUT/vdda (terminal)
Run mode: Single Run, Sweeps and Corners
