ADE simulation setup
Run mode: Single Run, Sweeps and Corners
Tests:
  cg_PLL_pll_core_tb_1: cg_PLL/pll_core_tb/schematic, simulator eldoD
    Variables: vdda = 1.2; reset = 0; r1 = 5k; icp = 10u; c2 = 4p; c1 = 40p; f_in = 40e6; iota = 5u
