ADE simulation setup
Run mode: Single Run, Sweeps and Corners
Tests:
  cg_PLL_pll_vco_symmetric_load_tb_1: cg_PLL/pll_vco_symmetric_load_tb/schematic, simulator eldoD
    Variables: vdda_vco = 1.2; vbp = 0
