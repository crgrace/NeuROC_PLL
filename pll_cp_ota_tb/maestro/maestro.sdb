ADE simulation setup
Run mode: Single Run, Sweeps and Corners
Tests:
  cg_PLL_pll_cp_ota_tb_1: cg_PLL/pll_cp_ota_tb/schematic, simulator eldoD
    Variables: vdda = 1.2; vcm = 0.6; ibias = 2.5u; cload = 200f; vcp = 400m; vcn = 600m
