ADE simulation setup
Test cg_PLL_pll_cp_ota_tb_1: cg_PLL/pll_cp_ota_tb/schematic, simulator eldoD
  Models: /eda/foundry/TSMC/TSMC65_VCAD_V1.7A_Base/Base_PDK/V1.7A_1/1p9m6x1z1u/tsmcN65/../models/eldo/toplevel.eldo[tt_lib]
  Variables: vcp = 400m; vcn = 600m; vdda = 1.2; vcm = 0.6; ibias = 2.5u; cload = 200f
  Analysis tran
  Analysis ac
  Analysis dc
Run mode: Single Run, Sweeps and Corners
