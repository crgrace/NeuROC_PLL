ADE simulation setup
Run mode: Single Run, Sweeps and Corners
Tests:
  cg_PLL_pll_cp_tb_1: cg_PLL/pll_cp_tb/schematic, simulator eldoD
    Variables: vdda = 1.2; i_ota = 50u; i_cp = 50u; f_in = 75e6; delta_f = 500k
