ADE simulation setup
Test cg_PLL_pll_cp_tb_1: cg_PLL/pll_cp_tb/schematic, simulator eldoD
  Models: /eda/foundry/TSMC/TSMC65_VCAD_V1.7A_Base/Base_PDK/V1.7A_1/1p9m6x1z1u/tsmcN65/../models/eldo/toplevel.eldo[tt_lib]
  Variables: vdda = 1.2; i_ota = 50u; i_cp = 50u; f_in = 75e6; delta_f = 500k
  Initial conditions: /vctrl = 0.9
  Analysis tran
  Analysis dc
Run mode: Single Run, Sweeps and Corners
