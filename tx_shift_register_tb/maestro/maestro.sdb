ADE simulation setup
Run mode: Single Run, Sweeps and Corners
Tests:
  cg_PLL_tx_shift_register_tb_1: cg_PLL/tx_shift_register_tb/schematic, simulator eldoD
    Variables: vdda = 1.2; f_in = 1.25e9
