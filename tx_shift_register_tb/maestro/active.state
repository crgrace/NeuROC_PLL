ADE simulation setup
Test cg_PLL_tx_shift_register_tb_1: cg_PLL/tx_shift_register_tb/schematic, simulator eldoD
  Models: /eda/foundry/TSMC/TSMC65_VCAD_V1.7A_Base/Base_PDK/V1.7A_1/1p9m6x1z1u/tsmcN65/../models/eldo/toplevel.eldo[tt_lib]
  Variables: vdda = 1.2; f_in = 1.25e9
  Analysis dc
  Analysis tran
Run mode: Single Run, Sweeps and Corners
