ADE simulation setup
Run mode: Single Run, Sweeps and Corners
Tests:
  cg_PLL_pll_vco_top_tb_1: cg_PLL/pll_vco_top_tb/schematic, simulator eldoD
    Variables: vdda_vco = 1.2; vctrl = 0.7; cload = 20f
